CAN PHY - digital loopback through the analog bus (Day 14)
* ============================================================
* A digital bit goes in, crosses a real differential bus, and
* comes back out as a digital bit.
*
*   TX_dig -> dac_bridge -> switch driver -> CANH/CANL
*          -> tanh comparator -> adc_bridge -> RX_dig
*
* POLARITY (get this right or nothing later works):
*   TX = 0  ->  driver ON  ->  DOMINANT  ->  Vdiff 2.0 V  ->  RX = 0
*   TX = 1  ->  driver OFF ->  RECESSIVE ->  Vdiff 0.0 V  ->  RX = 1
*
* Note the driver control is INVERTED from TX: dominant is logic 0
* but requires the switches CLOSED. Bdrv does that inversion.
*
* COMPARATOR (roadmap 3.8.6):
*   V = 2.5 * (1 - tanh(10 * (Vdiff - 0.7)))
*   Vdiff 0.0 -> 5.00 V (recessive, logic 1)
*   Vdiff 0.7 -> 2.50 V (threshold)
*   Vdiff 2.0 -> 0.00 V (dominant,  logic 0)
*
* PREDICTED:
*   dominant levels   3.500 / 1.500 / 2.000 V   (as Day 13)
*   TX -> RX loop delay  << 500 ns (one time quantum)
*   bit period 8.000 us  (125 kbit/s)
* ============================================================

.param VCC_V = 5.0
.param RON   = 45

Vcc   vcc  0  DC {VCC_V}
Vref  vref 0  DC 2.5

* ---------- bus ----------
Rterm1 canh canl 120
Rterm2 canh canl 120
Rbias1 canh vref 10k
Rbias2 canl vref 10k
Cbush  canh 0 1n
Cbusl  canl 0 1n
Rleak1 canh 0 100meg
Rleak2 canl 0 100meg

* ---------- digital TX stimulus : 125 kHz, 8 us period ----------
* starts recessive (5 V = logic 1), first dominant bit at t = 10 us
Vtx tx_a 0 PULSE(5 0 10u 20n 20n 4u 8u)
Rtx tx_a 0 1meg

Aadc_tx [tx_a] [tx_d] adcmod
.model adcmod adc_bridge(in_low=1.5 in_high=3.5)

* ---------- digital TX -> analog control voltage ----------
Adac_ctrl [tx_d] [tx_ctl] dacmod
.model dacmod dac_bridge(out_low=0 out_high=5 out_undef=2.5
+                        t_rise=20n t_fall=20n)

* ---------- invert: TX=0 (dominant) must CLOSE the switches ----------
Bdrv ctrl 0 V = 5 - V(tx_ctl)

* ---------- output driver ----------
Sh vcc  canh ctrl 0 swmod
Sl canl 0    ctrl 0 swmod
.model swmod SW(Vt=2.5 Vh=0.2 Ron={RON} Roff=1e9)

* ---------- differential receiver ----------
Bcomp rx_ana 0 V = 2.5*(1 - tanh(10*(V(canh)-V(canl)-0.7)))
Rcomp rx_ana 0 1meg

Aadc_rx [rx_ana] [rx_d] adcmod

* ---------- bring RX back to analog so we can measure it ----------
Adac_rx [rx_d] [rx_a] dacmod
Rrx rx_a 0 1k

.tran 20n 60u

.control
  run

  echo ""
  echo "=========== LEVELS ==========="
  * t = 12us is inside the first dominant bit (10us..14us)
  meas tran canh_dom  FIND v(canh) AT=12u
  meas tran canl_dom  FIND v(canl) AT=12u
  * t = 20us is inside a recessive interval
  meas tran canh_rec  FIND v(canh) AT=16u
  meas tran canl_rec  FIND v(canl) AT=16u

  echo ""
  echo "=========== POLARITY ==========="
  meas tran tx_at_dom FIND v(tx_a) AT=12u
  meas tran rx_at_dom FIND v(rx_a) AT=12u
  meas tran tx_at_rec FIND v(tx_a) AT=16u
  meas tran rx_at_rec FIND v(rx_a) AT=16u

  echo ""
  echo "=========== LOOP DELAY ==========="
  * TX falling edge at 10us -> RX must follow
  meas tran t_loop TRIG v(tx_a) VAL=2.5 FALL=1 TARG v(rx_a) VAL=2.5 FALL=1

  echo ""
  echo "=========== BIT PERIOD ==========="
  meas tran t_bit TRIG v(tx_a) VAL=2.5 FALL=1 TARG v(tx_a) VAL=2.5 FALL=2

  echo ""
  echo "=========== PREDICTED ==========="
  echo "canh_dom 3.498  canl_dom 1.502   canh_rec = canl_rec = 2.4998"
  echo "tx_at_dom 0  rx_at_dom 0   tx_at_rec 5  rx_at_rec 5"
  echo "t_loop  << 500n      t_bit  8.000u"
  echo ""
.endc

.end
